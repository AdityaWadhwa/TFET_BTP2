// Generated for: spectre
// Generated on: Feb 17 18:08:05 2020
// Design library name: inverter
// Design cell name: inv
// Design view name: av_extracted
simulator lang=spectre
global 0 vdd!
parameters vs=1
include "/home/install/FOUNDRY/analog/45nm/gpdk045/../models/spectre/gpdk045.scs" section=mc

// Library name: inverter
// Cell name: inv
// View name: av_extracted
PM0 (OUT IN vdd! vdd!) g45p1hvt w=(3e-07) l=4.5e-08 nf=1 as=4.2e-14 \
        ad=4.2e-14 ps=8.8e-07 pd=8.8e-07 nrd=1.16667 nrs=1.16667 \
        sa=1.4e-07 sb=1.4e-07 sd=160n sca=118.121 scb=0.0795488 \
        scc=0.0136537 m=(1)
NM0 (OUT IN 0 0) g45n1hvt w=(1.2e-07) l=4.5e-08 nf=1 as=1.68e-14 \
        ad=1.68e-14 ps=5.2e-07 pd=5.2e-07 nrd=1.16667 nrs=1.16667 \
        sa=1.4e-07 sb=1.4e-07 sd=160n sca=27.6536 scb=0.0307855 \
        scc=0.00226322 m=(1)
include "./_graphical_stimuli.scs"
simulatorOptions options psfversion="1.1.0" reltol=1e-3 vabstol=1e-6 \
    iabstol=1e-12 temp=27 tnom=27 scalem=1.0 scale=1.0 gmin=1e-12 rforce=1 \
    maxnotes=5 maxwarns=5 digits=5 cols=80 pivrel=1e-3 \
    sensfile="../psf/sens.output" checklimitdest=psf
tran tran stop=6u errpreset=conservative write="spectre.ic" \
    writefinal="spectre.fc" annotate=status maxiters=5
finalTimeOP info what=oppoint where=rawfile
modelParameter info what=models where=rawfile
element info what=inst where=rawfile
outputParameter info what=output where=rawfile
designParamVals info what=parameters where=rawfile
primitives info what=primitives where=rawfile
subckts info what=subckts where=rawfile
saveOptions options save=allpub pwr=all
