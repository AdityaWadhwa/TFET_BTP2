_v0 (0 0) vsource dc=0 type=dc
_vIN (IN 0) vsource val0=0 val1=1 delay=2u rise=200n fall=200n width=1u type=pulse
_vvdd! (vdd! 0) vsource dc=1 type=dc
